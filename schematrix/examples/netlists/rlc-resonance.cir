* RLC resonance
* generated by Schematrix
*@ {"ref": "C1", "sym": "capacitor", "value": "100 nF"}
C1 N001 OUT 100n
*@ {"ref": "L1", "sym": "inductor", "value": "10 mH"}
L1 N002 N001 10m
*@ {"ref": "R1", "sym": "resistor", "value": "31.6 \\ohm"}
R1 OUT 0 31.6
*@ {"ref": "V1", "sym": "vsrc", "props": {"length": 80, "kind": "ac"}, "value": "AC 1"}
V1 N002 0 AC 1
* directives
.ac dec 200 100 100k
.meas ac peak MAX vm(OUT)
.meas ac f0 WHEN vp(OUT)=0
.save all
.end
