* Inverting amplifier
* generated by Schematrix
*@ {"ref": "R1", "sym": "resistor", "value": "1 k\\ohm"}
R1 VIN N001 1k
*@ {"ref": "R2", "sym": "resistor", "value": "10 k\\ohm"}
R2 N001 VOUT 10k
*@ {"ref": "U1", "sym": "opamp"}
XU1 0 N001 VOUT OPAMP
*@ {"ref": "V1", "sym": "vsrc", "props": {"length": 80, "kind": "ac"}, "value": "SIN(0 100m 1k)"}
V1 VIN 0 SIN(0 100m 1k)
* default models
.subckt OPAMP inp inm out
* ideal-ish op-amp: gain 1e5, one pole at 10 Hz (GBW 1 MHz), 100 ohm output
Ein 1 0 inp inm 1e5
Rp 1 2 1k
Cp 2 0 15.9u
Eout 3 0 2 0 1
Ro 3 out 100
.ends OPAMP
* directives
.tran 10u 3m
.ac dec 20 10 10Meg
.save all
.end
